clear_filter_step: ideal passive layout-entry audit
Vstep source 0 PULSE(0 3.3 0 1p 1p 2e-05 4e-05)
Rseries source filtered 1000.0
Cfilter filtered 0 1e-09 IC=0
Rpull source 0 10000.0
.options reltol=1e-6 abstol=1e-12 vntol=1e-9 method=trap
.end
