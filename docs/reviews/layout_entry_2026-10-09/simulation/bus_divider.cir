bus_divider: ideal passive layout-entry audit
Vbus bus 0 0
R1 bus mid 280000.0
R2 mid adc 280000.0
R3 adc 0 39000.0
C5 adc 0 1e-08
.options reltol=1e-6 abstol=1e-12 vntol=1e-9 method=trap
.end
