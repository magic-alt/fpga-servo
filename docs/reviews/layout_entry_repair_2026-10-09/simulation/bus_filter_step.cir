bus_filter_step: ideal passive layout-entry audit
Vstep source 0 PULSE(0 1 0 1p 1p 0.006 0.012)
Rseries source filtered 36460.76794657763
Cfilter filtered 0 1e-08 IC=0
.options reltol=1e-6 abstol=1e-12 vntol=1e-9 method=trap
.end
