ocp_references: ideal passive layout-entry audit
Vrail rail 0 5
R50 rail hi 10000.0
R51 hi 0 160000.0
R52 rail lo 160000.0
R53 lo 0 10000.0
.options reltol=1e-6 abstol=1e-12 vntol=1e-9 method=trap
.end
